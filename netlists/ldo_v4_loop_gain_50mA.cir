* loop gain lg_50mA
.include cmos180.lib
iref pb 0 5e-06
mbias pb pb vin vin PMOS W=5e-06 L=1e-06 M=1 AD=2.5e-12 AS=2.5e-12 PD=1.1e-05 PS=1.1e-05
m5 tail pb vin vin PMOS W=4e-05 L=1e-06 M=1 AD=2e-11 AS=2e-11 PD=8.1e-05 PS=8.1e-05
m1 d1 fbi tail tail PMOS W=8.1e-05 L=1e-06 M=1 AD=4.05e-11 AS=4.05e-11 PD=0.000163 PS=0.000163
m2 ea vref tail tail PMOS W=8.1e-05 L=1e-06 M=1 AD=4.05e-11 AS=4.05e-11 PD=0.000163 PS=0.000163
m3 d1 d1 0 0 NMOS W=2.5e-05 L=3e-06 M=1 AD=1.25e-11 AS=1.25e-11 PD=5.1e-05 PS=5.1e-05
m4 ea d1 0 0 NMOS W=2.5e-05 L=3e-06 M=1 AD=1.25e-11 AS=1.25e-11 PD=5.1e-05 PS=5.1e-05
vref vref 0 0.6
mbs g pb vin vin PMOS W=2e-05 L=1e-06 M=1 AD=1e-11 AS=1e-11 PD=4.1e-05 PS=4.1e-05
mb 0 ea g g PMOS W=8e-06 L=5e-07 M=1 AD=4e-12 AS=4e-12 PD=1.7e-05 PS=1.7e-05
mp vout g vin vin PMOS W=1e-05 L=1.8e-07 M=300 AD=5e-12 AS=5e-12 PD=2.1e-05 PS=2.1e-05
r1 vout fb 90000.0
r2 fb 0 59999.99999999999
cl vout nesr 2.2e-06
resr nesr 0 0.01
lbrk fb fbi 1e9
cbrk fbi vt 1e3
vt vt 0 dc 0 ac 1
vin vin 0 1.8
il vout 0 0.05
.control
ac dec 100 1 1e9
let T = -v(fb)/v(fbi)
let tm = db(T)
let tp = 180/pi*cph(T)
wrdata lg_50mA.txt tm tp
.endc
.end
